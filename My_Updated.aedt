# Ansys Electronics Desktop project, version 2022.1
materials:
  vacuum: permittivity=1
  air: permittivity=1.0006 permeability=1.0000004
  pec: conductivity=1e+30

design HFSSDesign1 (HFSS, DrivenModal, model units mm)
variables:
  a = 3.4in
  b = 1.7in
  c = 10in
  d = 0.5in
  e = 0.11in
  f = 2.8in
  b2h = 1.81in
geometry:
  Box1 [air] = box(corner=(0mm, 0mm, 0mm), size=(a, b, c))
  Box2 = box(corner=(2.45in, b, 3.13in), size=(d, e+0.09in, f))
  Box4 = box(corner=(0mm, b2h+0.09in, 3in), size=(a, b, c-5in))
  Box1.unite(Box2)
  Box8 = box(corner=(0.45in, -0.11in-0.09in, 3.13in), size=(d, e+0.09in, f))
  Box1.unite(Box8)
  Rectangle1 = rectangle(corner=(0mm, 45.974mm, 203.2mm), x_size=86.36mm, y_size=43.18mm)
  Polyline1 = polyline(x=43.18mm, yz in mm: (67.564, 203.2) (70, 220) (100, 240), Spline from point 0 over 3)
  Rectangle1.sweep_along_path(Polyline1)
  Box4.unite(Rectangle1)
  Box1.unite(Box4)
  abc [pec] = box(corner=(0.01in, b-0.545in, 3.4in), size=(a-2in+0.35in-0.1in, e+0.435in, 0.4in))
  Box12 [pec] = box(corner=(2in-0.25in, 0.01in, 3.4in), size=(a-2in+0.25in, e+0.435in, 0.4in))
  Box13 = box(corner=(1.75in, b, 3.13in), size=(d, e+0.09in, f))
  Box1.unite(Box13)
  Box14 = box(corner=(0.44in+0.7in, -0.11in-0.09in, 3.13in), size=(d, e+0.09in, f))
  Box1.unite(Box14)
  Box15 = box(corner=(0mm, b2h+0.09in, 3in), size=(a, b, c-5in))
  Rectangle2 = rectangle(corner=(0mm, 45.974mm, 203.2mm), x_size=86.36mm, y_size=43.18mm)
  Polyline2 = polyline(x=43.18mm, yz in mm: (67.564, 203.2) (70, 220) (100, 240), Spline from point 0 over 3)
  Rectangle2.sweep_along_path(Polyline2)
  Box15.unite(Rectangle2)
  Box15_1 = Box15.duplicate_mirror(point=(0mm, 21.6mm, 0mm), normal=(0mm, -1mm, 0mm))
  Box15.delete()
  Box1.unite(Box15_1)
  Box16 [pec] = box(corner=(0mm, -5.06mm, 150.622mm), size=(86.36mm, 5.06mm, 52.58mm))
  Box16_1 [pec] = Box16.duplicate_mirror(point=(86.36mm, 21.59mm, 254mm), normal=(0mm, -1mm, 0mm))
boundaries and excitations:
  1: Wave Port Faces=Box1.face(-z) NumModes=1 Modes{Mode1{IntLine{(43.18, 0, 0) -> (43.18, 43.18, 0)} CharImp=Zpi}}
  2: Wave Port Faces=Box1.face(+z) NumModes=1 Modes{Mode1{IntLine{(43.18, 0, 254) -> (43.18, 43.18, 254)} CharImp=Zpi}}
  3: Wave Port Faces=Box1.face(#476) NumModes=1 Modes{Mode1{IntLine{(43.18, 91.672613, 259.91941) -> (43.18, 108.32739, 220.08059)} CharImp=Zpi}}
  4: Wave Port Faces=Box1.face(3 of 10) NumModes=1 Modes{Mode1{IntLine{(43.18, -48.472613, 259.91941) -> (43.18, -65.127387, 220.08059)} CharImp=Zpi}}
setups:
  Setup1: HfssDriven Frequency=2.45GHz MaxDeltaS=0.02 MaximumPasses=6 MinimumPasses=1 MinimumConvergedPasses=1 PercentRefinement=30 BasisOrder=1 PortAccuracy=2 DrivenSolverType="Direct Solver"
    sweep Sweep: 2.4GHz to 2.5GHz step 0.002GHz; Type=Fast SaveFields
source amplitudes:
  1:1: 1W 0deg
  2:1, 3:1, 4:1: 0W 0deg
reports:
  S Parameter Plot 1: dB(S(1,1)), dB(S(1,2)), dB(S(1,3)), dB(S(1,4)) vs Freq on Setup1 : Sweep; markers m1 at 2.45GHz, m2 at 2.45GHz, m3 at 2.45GHz, m4 at 2.45GHz
