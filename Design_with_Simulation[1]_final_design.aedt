# Ansys Electronics Desktop project, version 2022.1
materials:
  vacuum: permittivity=1
  air: permittivity=1.0006 permeability=1.0000004
  pec: conductivity=1e+30

design HFSSDesign1 (HFSS, DrivenModal, model units mm)
geometry:
  mainwaveguide [air] = box(corner=(0mm, 0mm, 0mm), size=(3.4in, 1.7in, 10in))
  pec_discon1 [pec] = box(corner=(0.01in, 1.155in, 3.4in), size=(1.65in, 0.545in, 0.41in))
  pec_discon2 [pec] = box(corner=(1.75in, 0.01in, 3.4in), size=(1.65in, 0.545in, 0.41in))
  slot1 = box(corner=(1.75in, 1.7in, 3.13in), size=(0.5in, 0.2in, 2.8in))
  slot2 = box(corner=(2.45in, 1.7in, 3.13in), size=(0.5in, 0.2in, 2.8in))
  slot3 = box(corner=(1.15in, -0.2in, 3.13in), size=(0.5in, 0.2in, 2.8in))
  slot4 = box(corner=(0.45in, -0.2in, 3.13in), size=(0.5in, 0.2in, 2.8in))
  couwaveguide1 = box(corner=(0mm, 1.9in, 3in), size=(3.4in, 1.7in, 5in))
  couwaveguide2 = box(corner=(0mm, -1.9in, 3in), size=(3.4in, 1.7in, 5in))
  mainwaveguide.unite(slot1..slot4)
  Rectangle1 = rectangle(corner=(0mm, 48.26mm, 203.2mm), x_size=86.36mm, y_size=43.18mm)
  Rectangle3 = rectangle(corner=(0mm, -48.26mm, 203.2mm), x_size=86.36mm, y_size=43.18mm)
  Polyline2 = polyline(x=43.18mm, yz in mm: (-26.67, 203.2) (-30, 230) (-50, 250), Spline from point 0 over 3)
  Rectangle3.sweep_along_path(Polyline2)
  couwaveguide2.unite(Rectangle3)
  mainwaveguide.unite(couwaveguide2)
  Polyline3 = polyline(x=43.18mm, yz in mm: (69.85, 203.2) (73.18, 230) (93.18, 250), Spline from point 0 over 3)
  Rectangle1.sweep_along_path(Polyline3)
  couwaveguide1.unite(Rectangle1)
  mainwaveguide.unite(couwaveguide1)
  pec_discon2.fillet(Edges=pec_discon2.edge(6 of 12) Radius=1.5mm Setback=0mm)
  pec_discon2.fillet(Edges=pec_discon2.edge(4 of 12) Radius=1.5mm Setback=0mm)
  pec_discon1.fillet(Edges=pec_discon1.edge(8 of 12) Radius=1.5mm Setback=0mm)
  pec_discon1.fillet(Edges=pec_discon1.edge(2 of 12) Radius=1.5mm Setback=0mm)
boundaries and excitations:
  1: Wave Port Faces=mainwaveguide.face(-z) NumModes=1 Modes{Mode1{IntLine{(43.18, 0, 0) -> (43.18, 43.18, 0)} CharImp=Zpi}}
  4: Wave Port Faces=mainwaveguide.face(#523) NumModes=1 Modes{Mode1{IntLine{(43.18, -37.469221, 267.58146) -> (43.18, -62.530779, 232.41854)} CharImp=Zpi}}
  2: Wave Port Faces=mainwaveguide.face(+z) NumModes=1 Modes{Mode1{IntLine{(43.18, 43.18, 254) -> (43.18, 0, 254)} CharImp=Zpi}}
  3: Wave Port Faces=mainwaveguide.face(#573) NumModes=1 Modes{Mode1{IntLine{(43.18, 80.649221, 267.58146) -> (43.18, 105.71078, 232.41854)} CharImp=Zpi}}
setups:
  Setup1: HfssDriven Frequency=2.45GHz MaxDeltaS=0.02 MaximumPasses=6 MinimumPasses=1 MinimumConvergedPasses=1 PercentRefinement=30 BasisOrder=1 PortAccuracy=2 DrivenSolverType="Direct Solver"
    sweep Sweep: 2.4GHz to 2.5GHz step 0.002GHz; Type=Fast SaveFields
source amplitudes:
  1:1: 1W 0deg
  4:1, 2:1, 3:1: 0W 0deg
reports:
  S Parameter Plot 1: dB(S(1,1)), dB(S(1,2)), dB(S(1,3)), dB(S(1,4)) vs Freq on Setup1 : Sweep; markers m1 at 2.45GHz, m2 at 2.45GHz, m3 at 2.5GHz
